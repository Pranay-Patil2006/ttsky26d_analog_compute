* NGSPICE file created from combined.ext - technology: sky130A

.subckt combined vdd_comp iz_lin iz_sq iy_sq ix_sq ix_lin iy_lin vt0 GND const_curr
+ vdd i_v_out out
X0 vdd net5 net6 vdd sky130_fd_pr__pfet_01v8 ad=0.58 pd=4.29 as=1.16 ps=8.58 w=4 l=2
X1 const_curr lin_out vdd_comp vdd sky130_fd_pr__pfet_01v8 ad=1.16 pd=8.29 as=1.16 ps=8.29 w=8 l=4
X2 iz_sq iy_sq net2 GND sky130_fd_pr__nfet_01v8 ad=2.32 pd=16.58 as=2.32 ps=16.58 w=8 l=4
X3 vdd_comp lin_out lin_out vdd sky130_fd_pr__pfet_01v8 ad=1.16 pd=8.29 as=1.16 ps=8.29 w=8 l=4
X4 GND vt0 GND GND sky130_fd_pr__nfet_01v8 ad=2.32 pd=16.58 as=438.48001 ps=3.13362k w=8 l=4
X5 vdd_comp lin_out const_curr vdd sky130_fd_pr__pfet_01v8 ad=1.16 pd=8.29 as=2.32 ps=16.58 w=8 l=4
X6 vdd_comp lin_out lin_out vdd sky130_fd_pr__pfet_01v8 ad=1.16 pd=8.29 as=1.16 ps=8.29 w=8 l=4
X7 GND GND GND GND sky130_fd_pr__nfet_01v8 ad=2.32 pd=16.58 as=0 ps=0 w=8 l=4
X8 iz_sq iy_sq net2 GND sky130_fd_pr__nfet_01v8 ad=2.32 pd=16.58 as=2.32 ps=16.58 w=8 l=4
X9 GND GND GND GND sky130_fd_pr__nfet_01v8 ad=2.32 pd=16.58 as=0 ps=0 w=8 l=4
X10 vdd_comp sq_out const_curr vdd sky130_fd_pr__pfet_01v8 ad=1.16 pd=8.29 as=1.16 ps=8.29 w=8 l=4
X11 vdd_comp sq_out sq_out vdd sky130_fd_pr__pfet_01v8 ad=1.16 pd=8.29 as=1.16 ps=8.29 w=8 l=4
X12 net5 const_curr GND GND sky130_fd_pr__nfet_01v8 ad=1.16 pd=8.29 as=1.16 ps=8.29 w=8 l=2
X13 net4 vt0 lin_out GND sky130_fd_pr__nfet_01v8 ad=2.32 pd=16.58 as=2.32 ps=16.58 w=8 l=4
X14 GND const_curr net5 GND sky130_fd_pr__nfet_01v8 ad=1.16 pd=8.29 as=1.16 ps=8.29 w=8 l=2
X15 net4 iy_lin iz_lin GND sky130_fd_pr__nfet_01v8 ad=2.32 pd=16.58 as=2.32 ps=16.58 w=8 l=4
X16 vdd_comp sq_out const_curr vdd sky130_fd_pr__pfet_01v8 ad=1.16 pd=8.29 as=1.16 ps=8.29 w=8 l=4
X17 GND GND GND GND sky130_fd_pr__nfet_01v8 ad=2.32 pd=16.58 as=0 ps=0 w=8 l=4
X18 vdd_comp lin_out const_curr vdd sky130_fd_pr__pfet_01v8 ad=1.16 pd=8.29 as=1.16 ps=8.29 w=8 l=4
X19 GND GND GND GND sky130_fd_pr__nfet_01v8 ad=2.32 pd=16.58 as=0 ps=0 w=8 l=4
X20 net1 iy_sq iy_sq GND sky130_fd_pr__nfet_01v8 ad=2.32 pd=16.58 as=2.32 ps=16.58 w=8 l=4
X21 vdd_comp lin_out const_curr vdd sky130_fd_pr__pfet_01v8 ad=1.16 pd=8.29 as=1.16 ps=8.29 w=8 l=4
X22 GND GND GND GND sky130_fd_pr__nfet_01v8 ad=2.32 pd=16.58 as=0 ps=0 w=8 l=4
X23 ix_sq vt0 net1 GND sky130_fd_pr__nfet_01v8 ad=2.32 pd=16.58 as=2.32 ps=16.58 w=8 l=4
X24 net1 iy_sq iy_sq GND sky130_fd_pr__nfet_01v8 ad=2.32 pd=16.58 as=2.32 ps=16.58 w=8 l=4
X25 GND const_curr const_curr GND sky130_fd_pr__nfet_01v8 ad=1.16 pd=8.29 as=1.16 ps=8.29 w=8 l=4
X26 iy_lin iy_lin net3 GND sky130_fd_pr__nfet_01v8 ad=2.32 pd=16.58 as=2.32 ps=16.58 w=8 l=4
X27 iz_sq iy_sq net2 GND sky130_fd_pr__nfet_01v8 ad=2.32 pd=16.58 as=2.32 ps=16.58 w=8 l=4
X28 sq_out vt0 net2 GND sky130_fd_pr__nfet_01v8 ad=2.32 pd=16.58 as=2.32 ps=16.58 w=8 l=4
X29 vdd_comp sq_out const_curr vdd sky130_fd_pr__pfet_01v8 ad=1.16 pd=8.29 as=1.16 ps=8.29 w=8 l=4
X30 net3 ix_lin out GND sky130_fd_pr__nfet_01v8 ad=0.348 pd=2.98 as=0.348 ps=2.98 w=1.2 l=4
X31 net1 iy_sq iy_sq GND sky130_fd_pr__nfet_01v8 ad=2.32 pd=16.58 as=2.32 ps=16.58 w=8 l=4
X32 const_curr lin_out vdd_comp vdd sky130_fd_pr__pfet_01v8 ad=1.16 pd=8.29 as=1.16 ps=8.29 w=8 l=4
X33 GND GND GND GND sky130_fd_pr__nfet_01v8 ad=2.32 pd=16.58 as=0 ps=0 w=8 l=4
X34 vdd_comp sq_out sq_out vdd sky130_fd_pr__pfet_01v8 ad=1.16 pd=8.29 as=1.16 ps=8.29 w=8 l=4
X35 const_curr sq_out vdd_comp vdd sky130_fd_pr__pfet_01v8 ad=1.16 pd=8.29 as=1.16 ps=8.29 w=8 l=4
X36 GND GND GND GND sky130_fd_pr__nfet_01v8 ad=2.32 pd=16.58 as=0 ps=0 w=8 l=4
X37 GND const_curr net5 GND sky130_fd_pr__nfet_01v8 ad=1.16 pd=8.29 as=1.16 ps=8.29 w=8 l=2
X38 GND const_curr const_curr GND sky130_fd_pr__nfet_01v8 ad=1.16 pd=8.29 as=1.16 ps=8.29 w=8 l=4
X39 ix_sq vt0 net1 GND sky130_fd_pr__nfet_01v8 ad=2.32 pd=16.58 as=2.32 ps=16.58 w=8 l=4
X40 vdd_comp lin_out lin_out vdd sky130_fd_pr__pfet_01v8 ad=1.16 pd=8.29 as=1.16 ps=8.29 w=8 l=4
X41 const_curr const_curr GND GND sky130_fd_pr__nfet_01v8 ad=2.32 pd=16.58 as=1.16 ps=8.29 w=8 l=4
X42 GND GND GND GND sky130_fd_pr__nfet_01v8 ad=2.32 pd=16.58 as=0 ps=0 w=8 l=4
X43 net1 vt0 ix_sq GND sky130_fd_pr__nfet_01v8 ad=2.32 pd=16.58 as=2.32 ps=16.58 w=8 l=4
X44 sq_out vt0 net2 GND sky130_fd_pr__nfet_01v8 ad=2.32 pd=16.58 as=2.32 ps=16.58 w=8 l=4
X45 sq_out sq_out vdd_comp vdd sky130_fd_pr__pfet_01v8 ad=1.16 pd=8.29 as=1.16 ps=8.29 w=8 l=4
X46 GND GND GND GND sky130_fd_pr__nfet_01v8 ad=2.32 pd=16.58 as=0 ps=0 w=8 l=4
X47 lin_out lin_out vdd_comp vdd sky130_fd_pr__pfet_01v8 ad=1.16 pd=8.29 as=1.16 ps=8.29 w=8 l=4
X48 net5 const_curr GND GND sky130_fd_pr__nfet_01v8 ad=1.16 pd=8.29 as=1.16 ps=8.29 w=8 l=2
X49 GND const_curr const_curr GND sky130_fd_pr__nfet_01v8 ad=1.16 pd=8.29 as=1.16 ps=8.29 w=8 l=4
X50 GND GND GND GND sky130_fd_pr__nfet_01v8 ad=2.32 pd=16.58 as=0 ps=0 w=8 l=4
X51 GND const_curr net5 GND sky130_fd_pr__nfet_01v8 ad=1.16 pd=8.29 as=1.16 ps=8.29 w=8 l=2
X52 iy_sq iy_sq net1 GND sky130_fd_pr__nfet_01v8 ad=2.32 pd=16.58 as=2.32 ps=16.58 w=8 l=4
X53 net2 iy_sq iz_sq GND sky130_fd_pr__nfet_01v8 ad=2.32 pd=16.58 as=2.32 ps=16.58 w=8 l=4
X54 GND net6 net6 GND sky130_fd_pr__nfet_01v8 ad=1.16 pd=8.29 as=2.32 ps=16.58 w=8 l=2
X55 GND GND GND GND sky130_fd_pr__nfet_01v8 ad=2.32 pd=16.58 as=0 ps=0 w=8 l=4
X56 net3 vt0 ix_lin GND sky130_fd_pr__nfet_01v8 ad=2.32 pd=16.58 as=2.32 ps=16.58 w=8 l=4
X57 net5 const_curr GND GND sky130_fd_pr__nfet_01v8 ad=1.16 pd=8.29 as=1.16 ps=8.29 w=8 l=2
X58 net4 vt0 lin_out GND sky130_fd_pr__nfet_01v8 ad=2.32 pd=16.58 as=2.32 ps=16.58 w=8 l=4
X59 GND GND GND GND sky130_fd_pr__nfet_01v8 ad=2.32 pd=16.58 as=0 ps=0 w=8 l=4
X60 GND GND GND GND sky130_fd_pr__nfet_01v8 ad=2.32 pd=16.58 as=0 ps=0 w=8 l=4
X61 net1 vt0 ix_sq GND sky130_fd_pr__nfet_01v8 ad=2.32 pd=16.58 as=2.32 ps=16.58 w=8 l=4
X62 GND const_curr net5 GND sky130_fd_pr__nfet_01v8 ad=1.16 pd=8.29 as=1.16 ps=8.29 w=8 l=2
X63 const_curr const_curr GND GND sky130_fd_pr__nfet_01v8 ad=1.16 pd=8.29 as=1.16 ps=8.29 w=8 l=4
X64 GND GND GND GND sky130_fd_pr__nfet_01v8 ad=2.32 pd=16.58 as=0 ps=0 w=8 l=4
X65 GND GND GND GND sky130_fd_pr__nfet_01v8 ad=2.32 pd=16.58 as=0 ps=0 w=8 l=4
X66 net2 iy_sq iz_sq GND sky130_fd_pr__nfet_01v8 ad=2.32 pd=16.58 as=2.32 ps=16.58 w=8 l=4
X67 GND vt0 GND GND sky130_fd_pr__nfet_01v8 ad=2.32 pd=16.58 as=0 ps=0 w=8 l=4
X68 GND vt0 GND GND sky130_fd_pr__nfet_01v8 ad=2.32 pd=16.58 as=0 ps=0 w=8 l=4
X69 const_curr sq_out vdd_comp vdd sky130_fd_pr__pfet_01v8 ad=1.16 pd=8.29 as=1.16 ps=8.29 w=8 l=4
X70 GND const_curr net5 GND sky130_fd_pr__nfet_01v8 ad=1.16 pd=8.29 as=1.16 ps=8.29 w=8 l=2
X71 net1 vt0 ix_sq GND sky130_fd_pr__nfet_01v8 ad=2.32 pd=16.58 as=2.32 ps=16.58 w=8 l=4
X72 vdd_comp lin_out lin_out vdd sky130_fd_pr__pfet_01v8 ad=1.16 pd=8.29 as=1.16 ps=8.29 w=8 l=4
X73 GND GND GND GND sky130_fd_pr__nfet_01v8 ad=2.32 pd=16.58 as=0 ps=0 w=8 l=4
X74 ix_lin vt0 net3 GND sky130_fd_pr__nfet_01v8 ad=2.32 pd=16.58 as=2.32 ps=16.58 w=8 l=4
X75 GND const_curr const_curr GND sky130_fd_pr__nfet_01v8 ad=1.16 pd=8.29 as=1.16 ps=8.29 w=8 l=4
X76 iy_sq iy_sq net1 GND sky130_fd_pr__nfet_01v8 ad=2.32 pd=16.58 as=2.32 ps=16.58 w=8 l=4
X77 const_curr const_curr GND GND sky130_fd_pr__nfet_01v8 ad=1.16 pd=8.29 as=1.16 ps=8.29 w=8 l=4
X78 ix_lin vt0 net3 GND sky130_fd_pr__nfet_01v8 ad=2.32 pd=16.58 as=2.32 ps=16.58 w=8 l=4
X79 lin_out lin_out vdd_comp vdd sky130_fd_pr__pfet_01v8 ad=1.16 pd=8.29 as=1.16 ps=8.29 w=8 l=4
X80 GND GND GND GND sky130_fd_pr__nfet_01v8 ad=2.32 pd=16.58 as=0 ps=0 w=8 l=4
X81 vdd_comp sq_out const_curr vdd sky130_fd_pr__pfet_01v8 ad=1.16 pd=8.29 as=1.16 ps=8.29 w=8 l=4
X82 GND vt0 GND GND sky130_fd_pr__nfet_01v8 ad=2.32 pd=16.58 as=0 ps=0 w=8 l=4
X83 net4 iy_lin iz_lin GND sky130_fd_pr__nfet_01v8 ad=2.32 pd=16.58 as=2.32 ps=16.58 w=8 l=4
X84 GND const_curr net5 GND sky130_fd_pr__nfet_01v8 ad=1.16 pd=8.29 as=1.16 ps=8.29 w=8 l=2
X85 net1 vt0 ix_sq GND sky130_fd_pr__nfet_01v8 ad=2.32 pd=16.58 as=2.32 ps=16.58 w=8 l=4
X86 sq_out sq_out vdd_comp vdd sky130_fd_pr__pfet_01v8 ad=1.16 pd=8.29 as=1.16 ps=8.29 w=8 l=4
X87 net5 const_curr GND GND sky130_fd_pr__nfet_01v8 ad=1.16 pd=8.29 as=1.16 ps=8.29 w=8 l=2
X88 GND GND GND GND sky130_fd_pr__nfet_01v8 ad=2.32 pd=16.58 as=0 ps=0 w=8 l=4
X89 GND GND GND GND sky130_fd_pr__nfet_01v8 ad=2.32 pd=16.58 as=0 ps=0 w=8 l=4
X90 iy_sq iy_sq net1 GND sky130_fd_pr__nfet_01v8 ad=2.32 pd=16.58 as=2.32 ps=16.58 w=8 l=4
X91 net1 vt0 ix_sq GND sky130_fd_pr__nfet_01v8 ad=2.32 pd=16.58 as=2.32 ps=16.58 w=8 l=4
X92 GND vt0 GND GND sky130_fd_pr__nfet_01v8 ad=2.32 pd=16.58 as=0 ps=0 w=8 l=4
X93 GND vt0 GND GND sky130_fd_pr__nfet_01v8 ad=2.32 pd=16.58 as=0 ps=0 w=8 l=4
X94 vdd_comp lin_out const_curr vdd sky130_fd_pr__pfet_01v8 ad=1.16 pd=8.29 as=1.16 ps=8.29 w=8 l=4
X95 const_curr const_curr GND GND sky130_fd_pr__nfet_01v8 ad=1.16 pd=8.29 as=1.16 ps=8.29 w=8 l=4
X96 const_curr const_curr GND GND sky130_fd_pr__nfet_01v8 ad=1.16 pd=8.29 as=1.16 ps=8.29 w=8 l=4
X97 const_curr lin_out vdd_comp vdd sky130_fd_pr__pfet_01v8 ad=1.16 pd=8.29 as=1.16 ps=8.29 w=8 l=4
X98 sq_out sq_out vdd_comp vdd sky130_fd_pr__pfet_01v8 ad=1.16 pd=8.29 as=1.16 ps=8.29 w=8 l=4
X99 net1 iy_sq iy_sq GND sky130_fd_pr__nfet_01v8 ad=2.32 pd=16.58 as=2.32 ps=16.58 w=8 l=4
X100 net3 iy_lin iy_lin GND sky130_fd_pr__nfet_01v8 ad=2.32 pd=16.58 as=2.32 ps=16.58 w=8 l=4
X101 GND GND GND GND sky130_fd_pr__nfet_01v8 ad=2.32 pd=16.58 as=0 ps=0 w=8 l=4
X102 vdd_comp sq_out sq_out vdd sky130_fd_pr__pfet_01v8 ad=1.16 pd=8.29 as=1.16 ps=8.29 w=8 l=4
X103 net1 vt0 ix_sq GND sky130_fd_pr__nfet_01v8 ad=2.32 pd=16.58 as=2.32 ps=16.58 w=8 l=4
X104 const_curr const_curr GND GND sky130_fd_pr__nfet_01v8 ad=1.16 pd=8.29 as=1.16 ps=8.29 w=8 l=4
X105 GND GND GND GND sky130_fd_pr__nfet_01v8 ad=2.32 pd=16.58 as=0 ps=0 w=8 l=4
X106 GND GND GND GND sky130_fd_pr__nfet_01v8 ad=2.32 pd=16.58 as=0 ps=0 w=8 l=4
X107 iz_sq iy_sq net2 GND sky130_fd_pr__nfet_01v8 ad=2.32 pd=16.58 as=2.32 ps=16.58 w=8 l=4
X108 GND GND GND GND sky130_fd_pr__nfet_01v8 ad=2.32 pd=16.58 as=0 ps=0 w=8 l=4
X109 const_curr lin_out vdd_comp vdd sky130_fd_pr__pfet_01v8 ad=1.16 pd=8.29 as=1.16 ps=8.29 w=8 l=4
X110 vdd_comp lin_out lin_out vdd sky130_fd_pr__pfet_01v8 ad=1.16 pd=8.29 as=2.32 ps=16.58 w=8 l=4
X111 vdd_comp sq_out const_curr vdd sky130_fd_pr__pfet_01v8 ad=1.16 pd=8.29 as=1.16 ps=8.29 w=8 l=4
X112 iz_lin iy_lin net4 GND sky130_fd_pr__nfet_01v8 ad=2.32 pd=16.58 as=2.32 ps=16.58 w=8 l=4
X113 net5 const_curr GND GND sky130_fd_pr__nfet_01v8 ad=1.16 pd=8.29 as=1.16 ps=8.29 w=8 l=2
X114 GND const_curr net5 GND sky130_fd_pr__nfet_01v8 ad=1.16 pd=8.29 as=1.16 ps=8.29 w=8 l=2
X115 net2 vt0 sq_out GND sky130_fd_pr__nfet_01v8 ad=2.32 pd=16.58 as=2.32 ps=16.58 w=8 l=4
X116 GND GND GND GND sky130_fd_pr__nfet_01v8 ad=2.32 pd=16.58 as=0 ps=0 w=8 l=4
X117 lin_out vt0 net4 GND sky130_fd_pr__nfet_01v8 ad=2.32 pd=16.58 as=2.32 ps=16.58 w=8 l=4
X118 GND GND GND GND sky130_fd_pr__nfet_01v8 ad=2.32 pd=16.58 as=0 ps=0 w=8 l=4
X119 vdd_comp lin_out lin_out vdd sky130_fd_pr__pfet_01v8 ad=1.16 pd=8.29 as=1.16 ps=8.29 w=8 l=4
X120 vdd_comp sq_out const_curr vdd sky130_fd_pr__pfet_01v8 ad=1.16 pd=8.29 as=2.32 ps=16.58 w=8 l=4
X121 GND GND GND GND sky130_fd_pr__nfet_01v8 ad=2.32 pd=16.58 as=0 ps=0 w=8 l=4
X122 net1 vt0 ix_sq GND sky130_fd_pr__nfet_01v8 ad=2.32 pd=16.58 as=2.32 ps=16.58 w=8 l=4
X123 GND GND GND GND sky130_fd_pr__nfet_01v8 ad=2.32 pd=16.58 as=0 ps=0 w=8 l=4
X124 net1 vt0 ix_sq GND sky130_fd_pr__nfet_01v8 ad=2.32 pd=16.58 as=2.32 ps=16.58 w=8 l=4
X125 iz_lin iy_lin net4 GND sky130_fd_pr__nfet_01v8 ad=2.32 pd=16.58 as=2.32 ps=16.58 w=8 l=4
X126 ix_lin vt0 net3 GND sky130_fd_pr__nfet_01v8 ad=2.32 pd=16.58 as=2.32 ps=16.58 w=8 l=4
X127 ix_sq vt0 net1 GND sky130_fd_pr__nfet_01v8 ad=2.32 pd=16.58 as=2.32 ps=16.58 w=8 l=4
X128 GND GND GND GND sky130_fd_pr__nfet_01v8 ad=2.32 pd=16.58 as=0 ps=0 w=8 l=4
X129 net3 iy_lin iy_lin GND sky130_fd_pr__nfet_01v8 ad=2.32 pd=16.58 as=2.32 ps=16.58 w=8 l=4
X130 net6 net5 vdd vdd sky130_fd_pr__pfet_01v8 ad=0.58 pd=4.29 as=1.16 ps=8.58 w=4 l=2
X131 net1 ix_sq out GND sky130_fd_pr__nfet_01v8 ad=0.348 pd=2.98 as=0.348 ps=2.98 w=1.2 l=4
X132 vdd_comp lin_out const_curr vdd sky130_fd_pr__pfet_01v8 ad=1.16 pd=8.29 as=1.16 ps=8.29 w=8 l=4
X133 ix_sq vt0 net1 GND sky130_fd_pr__nfet_01v8 ad=2.32 pd=16.58 as=2.32 ps=16.58 w=8 l=4
X134 net3 iy_lin iy_lin GND sky130_fd_pr__nfet_01v8 ad=2.32 pd=16.58 as=2.32 ps=16.58 w=8 l=4
X135 net4 iy_lin iz_lin GND sky130_fd_pr__nfet_01v8 ad=2.32 pd=16.58 as=2.32 ps=16.58 w=8 l=4
X136 GND const_curr net5 GND sky130_fd_pr__nfet_01v8 ad=1.16 pd=8.29 as=1.16 ps=8.29 w=8 l=2
X137 GND GND GND GND sky130_fd_pr__nfet_01v8 ad=2.32 pd=16.58 as=0 ps=0 w=8 l=4
X138 sq_out vt0 net2 GND sky130_fd_pr__nfet_01v8 ad=2.32 pd=16.58 as=2.32 ps=16.58 w=8 l=4
X139 net2 vt0 sq_out GND sky130_fd_pr__nfet_01v8 ad=2.32 pd=16.58 as=2.32 ps=16.58 w=8 l=4
X140 net4 vt0 lin_out GND sky130_fd_pr__nfet_01v8 ad=2.32 pd=16.58 as=2.32 ps=16.58 w=8 l=4
X141 vdd_comp sq_out sq_out vdd sky130_fd_pr__pfet_01v8 ad=1.16 pd=8.29 as=1.16 ps=8.29 w=8 l=4
X142 net2 iy_sq iz_sq GND sky130_fd_pr__nfet_01v8 ad=2.32 pd=16.58 as=2.32 ps=16.58 w=8 l=4
X143 net2 vt0 sq_out GND sky130_fd_pr__nfet_01v8 ad=2.32 pd=16.58 as=2.32 ps=16.58 w=8 l=4
X144 net1 iy_sq iy_sq GND sky130_fd_pr__nfet_01v8 ad=2.32 pd=16.58 as=2.32 ps=16.58 w=8 l=4
X145 lin_out lin_out vdd_comp vdd sky130_fd_pr__pfet_01v8 ad=1.16 pd=8.29 as=1.16 ps=8.29 w=8 l=4
X146 net5 const_curr GND GND sky130_fd_pr__nfet_01v8 ad=1.16 pd=8.29 as=1.16 ps=8.29 w=8 l=2
X147 GND GND GND GND sky130_fd_pr__nfet_01v8 ad=2.32 pd=16.58 as=0 ps=0 w=8 l=4
X148 GND GND GND GND sky130_fd_pr__nfet_01v8 ad=2.32 pd=16.58 as=0 ps=0 w=8 l=4
X149 GND vt0 GND GND sky130_fd_pr__nfet_01v8 ad=2.32 pd=16.58 as=0 ps=0 w=8 l=4
X150 GND vt0 GND GND sky130_fd_pr__nfet_01v8 ad=2.32 pd=16.58 as=0 ps=0 w=8 l=4
X151 ix_sq vt0 net1 GND sky130_fd_pr__nfet_01v8 ad=2.32 pd=16.58 as=2.32 ps=16.58 w=8 l=4
X152 vdd_comp lin_out lin_out vdd sky130_fd_pr__pfet_01v8 ad=1.16 pd=8.29 as=1.16 ps=8.29 w=8 l=4
X153 iz_lin iy_lin net4 GND sky130_fd_pr__nfet_01v8 ad=2.32 pd=16.58 as=2.32 ps=16.58 w=8 l=4
X154 GND vt0 GND GND sky130_fd_pr__nfet_01v8 ad=2.32 pd=16.58 as=0 ps=0 w=8 l=4
X155 net6 net5 vdd vdd sky130_fd_pr__pfet_01v8 ad=0.58 pd=4.29 as=0.58 ps=4.29 w=4 l=2
X156 vdd net5 net6 vdd sky130_fd_pr__pfet_01v8 ad=1.16 pd=8.58 as=0.58 ps=4.29 w=4 l=2
X157 const_curr sq_out vdd_comp vdd sky130_fd_pr__pfet_01v8 ad=1.16 pd=8.29 as=1.16 ps=8.29 w=8 l=4
X158 ix_sq vt0 net1 GND sky130_fd_pr__nfet_01v8 ad=2.32 pd=16.58 as=2.32 ps=16.58 w=8 l=4
X159 vdd_comp sq_out const_curr vdd sky130_fd_pr__pfet_01v8 ad=1.16 pd=8.29 as=1.16 ps=8.29 w=8 l=4
X160 GND GND GND GND sky130_fd_pr__nfet_01v8 ad=2.32 pd=16.58 as=0 ps=0 w=8 l=4
X161 iz_lin iy_lin net4 GND sky130_fd_pr__nfet_01v8 ad=2.32 pd=16.58 as=2.32 ps=16.58 w=8 l=4
X162 GND const_curr net5 GND sky130_fd_pr__nfet_01v8 ad=1.16 pd=8.29 as=1.16 ps=8.29 w=8 l=2
X163 iz_sq iy_sq net2 GND sky130_fd_pr__nfet_01v8 ad=2.32 pd=16.58 as=2.32 ps=16.58 w=8 l=4
X164 GND GND GND GND sky130_fd_pr__nfet_01v8 ad=2.32 pd=16.58 as=0 ps=0 w=8 l=4
X165 const_curr const_curr GND GND sky130_fd_pr__nfet_01v8 ad=1.16 pd=8.29 as=1.16 ps=8.29 w=8 l=4
X166 net1 iy_sq iy_sq GND sky130_fd_pr__nfet_01v8 ad=2.32 pd=16.58 as=2.32 ps=16.58 w=8 l=4
X167 iy_sq iy_sq net1 GND sky130_fd_pr__nfet_01v8 ad=2.32 pd=16.58 as=2.32 ps=16.58 w=8 l=4
X168 net2 vt0 sq_out GND sky130_fd_pr__nfet_01v8 ad=2.32 pd=16.58 as=2.32 ps=16.58 w=8 l=4
X169 vdd_comp lin_out const_curr vdd sky130_fd_pr__pfet_01v8 ad=1.16 pd=8.29 as=1.16 ps=8.29 w=8 l=4
X170 iz_sq iy_sq net2 GND sky130_fd_pr__nfet_01v8 ad=2.32 pd=16.58 as=2.32 ps=16.58 w=8 l=4
X171 GND const_curr const_curr GND sky130_fd_pr__nfet_01v8 ad=1.16 pd=8.29 as=1.16 ps=8.29 w=8 l=4
X172 GND GND GND GND sky130_fd_pr__nfet_01v8 ad=2.32 pd=16.58 as=0 ps=0 w=8 l=4
X173 GND GND GND GND sky130_fd_pr__nfet_01v8 ad=2.32 pd=16.58 as=0 ps=0 w=8 l=4
X174 net4 vt0 lin_out GND sky130_fd_pr__nfet_01v8 ad=2.32 pd=16.58 as=2.32 ps=16.58 w=8 l=4
X175 GND GND GND GND sky130_fd_pr__nfet_01v8 ad=2.32 pd=16.58 as=0 ps=0 w=8 l=4
X176 const_curr const_curr GND GND sky130_fd_pr__nfet_01v8 ad=1.16 pd=8.29 as=1.16 ps=8.29 w=8 l=4
X177 GND GND GND GND sky130_fd_pr__nfet_01v8 ad=2.32 pd=16.58 as=0 ps=0 w=8 l=4
X178 iy_sq iy_sq net1 GND sky130_fd_pr__nfet_01v8 ad=2.32 pd=16.58 as=2.32 ps=16.58 w=8 l=4
X179 GND GND GND GND sky130_fd_pr__nfet_01v8 ad=2.32 pd=16.58 as=0 ps=0 w=8 l=4
X180 vdd net5 net6 vdd sky130_fd_pr__pfet_01v8 ad=0.58 pd=4.29 as=0.58 ps=4.29 w=4 l=2
X181 iy_sq iy_sq net1 GND sky130_fd_pr__nfet_01v8 ad=2.32 pd=16.58 as=2.32 ps=16.58 w=8 l=4
X182 net3 iy_lin iy_lin GND sky130_fd_pr__nfet_01v8 ad=2.32 pd=16.58 as=2.32 ps=16.58 w=8 l=4
X183 net6 net5 vdd vdd sky130_fd_pr__pfet_01v8 ad=1.16 pd=8.58 as=0.58 ps=4.29 w=4 l=2
X184 vdd_comp sq_out sq_out vdd sky130_fd_pr__pfet_01v8 ad=1.16 pd=8.29 as=1.16 ps=8.29 w=8 l=4
X185 net1 vt0 ix_sq GND sky130_fd_pr__nfet_01v8 ad=2.32 pd=16.58 as=2.32 ps=16.58 w=8 l=4
X186 GND const_curr const_curr GND sky130_fd_pr__nfet_01v8 ad=1.16 pd=8.29 as=1.16 ps=8.29 w=8 l=4
X187 GND GND GND GND sky130_fd_pr__nfet_01v8 ad=2.32 pd=16.58 as=0 ps=0 w=8 l=4
X188 ix_sq vt0 net1 GND sky130_fd_pr__nfet_01v8 ad=2.32 pd=16.58 as=2.32 ps=16.58 w=8 l=4
X189 net3 iy_lin iy_lin GND sky130_fd_pr__nfet_01v8 ad=2.32 pd=16.58 as=2.32 ps=16.58 w=8 l=4
X190 lin_out lin_out vdd_comp vdd sky130_fd_pr__pfet_01v8 ad=1.16 pd=8.29 as=1.16 ps=8.29 w=8 l=4
X191 ix_sq vt0 net1 GND sky130_fd_pr__nfet_01v8 ad=2.32 pd=16.58 as=2.32 ps=16.58 w=8 l=4
X192 net3 iy_lin iy_lin GND sky130_fd_pr__nfet_01v8 ad=2.32 pd=16.58 as=2.32 ps=16.58 w=8 l=4
X193 GND GND GND GND sky130_fd_pr__nfet_01v8 ad=2.32 pd=16.58 as=0 ps=0 w=8 l=4
X194 net2 iy_sq iz_sq GND sky130_fd_pr__nfet_01v8 ad=2.32 pd=16.58 as=2.32 ps=16.58 w=8 l=4
X195 iy_sq iy_sq net1 GND sky130_fd_pr__nfet_01v8 ad=2.32 pd=16.58 as=2.32 ps=16.58 w=8 l=4
X196 const_curr const_curr GND GND sky130_fd_pr__nfet_01v8 ad=1.16 pd=8.29 as=1.16 ps=8.29 w=8 l=4
X197 net2 iz_sq out GND sky130_fd_pr__nfet_01v8 ad=0.348 pd=2.98 as=0.348 ps=2.98 w=1.2 l=4
X198 sq_out vt0 net2 GND sky130_fd_pr__nfet_01v8 ad=2.32 pd=16.58 as=2.32 ps=16.58 w=8 l=4
X199 GND GND GND GND sky130_fd_pr__nfet_01v8 ad=2.32 pd=16.58 as=0 ps=0 w=8 l=4
X200 ix_lin vt0 net3 GND sky130_fd_pr__nfet_01v8 ad=2.32 pd=16.58 as=2.32 ps=16.58 w=8 l=4
X201 GND GND GND GND sky130_fd_pr__nfet_01v8 ad=2.32 pd=16.58 as=0 ps=0 w=8 l=4
X202 iy_sq iy_sq net1 GND sky130_fd_pr__nfet_01v8 ad=2.32 pd=16.58 as=2.32 ps=16.58 w=8 l=4
X203 lin_out vt0 net4 GND sky130_fd_pr__nfet_01v8 ad=2.32 pd=16.58 as=2.32 ps=16.58 w=8 l=4
X204 const_curr sq_out vdd_comp vdd sky130_fd_pr__pfet_01v8 ad=1.16 pd=8.29 as=1.16 ps=8.29 w=8 l=4
X205 GND GND GND GND sky130_fd_pr__nfet_01v8 ad=2.32 pd=16.58 as=0 ps=0 w=8 l=4
X206 lin_out vt0 net4 GND sky130_fd_pr__nfet_01v8 ad=2.32 pd=16.58 as=2.32 ps=16.58 w=8 l=4
X207 GND GND GND GND sky130_fd_pr__nfet_01v8 ad=2.32 pd=16.58 as=0 ps=0 w=8 l=4
X208 net2 iy_sq iz_sq GND sky130_fd_pr__nfet_01v8 ad=2.32 pd=16.58 as=2.32 ps=16.58 w=8 l=4
X209 GND GND GND GND sky130_fd_pr__nfet_01v8 ad=2.32 pd=16.58 as=0 ps=0 w=8 l=4
X210 iz_sq iy_sq net2 GND sky130_fd_pr__nfet_01v8 ad=2.32 pd=16.58 as=2.32 ps=16.58 w=8 l=4
X211 sq_out sq_out vdd_comp vdd sky130_fd_pr__pfet_01v8 ad=2.32 pd=16.58 as=1.16 ps=8.29 w=8 l=4
X212 GND const_curr const_curr GND sky130_fd_pr__nfet_01v8 ad=1.16 pd=8.29 as=1.16 ps=8.29 w=8 l=4
X213 GND GND GND GND sky130_fd_pr__nfet_01v8 ad=2.32 pd=16.58 as=0 ps=0 w=8 l=4
X214 const_curr lin_out vdd_comp vdd sky130_fd_pr__pfet_01v8 ad=1.16 pd=8.29 as=1.16 ps=8.29 w=8 l=4
X215 iy_sq iy_sq net1 GND sky130_fd_pr__nfet_01v8 ad=2.32 pd=16.58 as=2.32 ps=16.58 w=8 l=4
X216 sq_out vt0 net2 GND sky130_fd_pr__nfet_01v8 ad=2.32 pd=16.58 as=2.32 ps=16.58 w=8 l=4
X217 net4 vt0 lin_out GND sky130_fd_pr__nfet_01v8 ad=2.32 pd=16.58 as=2.32 ps=16.58 w=8 l=4
X218 GND vt0 GND GND sky130_fd_pr__nfet_01v8 ad=2.32 pd=16.58 as=0 ps=0 w=8 l=4
X219 GND GND GND GND sky130_fd_pr__nfet_01v8 ad=2.32 pd=16.58 as=0 ps=0 w=8 l=4
X220 const_curr lin_out vdd_comp vdd sky130_fd_pr__pfet_01v8 ad=2.32 pd=16.58 as=1.16 ps=8.29 w=8 l=4
X221 GND GND GND GND sky130_fd_pr__nfet_01v8 ad=2.32 pd=16.58 as=0 ps=0 w=8 l=4
X222 iz_sq iy_sq net2 GND sky130_fd_pr__nfet_01v8 ad=2.32 pd=16.58 as=2.32 ps=16.58 w=8 l=4
X223 net4 vt0 lin_out GND sky130_fd_pr__nfet_01v8 ad=2.32 pd=16.58 as=2.32 ps=16.58 w=8 l=4
X224 GND GND GND GND sky130_fd_pr__nfet_01v8 ad=2.32 pd=16.58 as=0 ps=0 w=8 l=4
X225 net5 net5 vdd vdd sky130_fd_pr__pfet_01v8 ad=1.16 pd=8.58 as=1.16 ps=8.58 w=4 l=2
X226 sq_out sq_out vdd_comp vdd sky130_fd_pr__pfet_01v8 ad=1.16 pd=8.29 as=1.16 ps=8.29 w=8 l=4
X227 const_curr sq_out vdd_comp vdd sky130_fd_pr__pfet_01v8 ad=1.16 pd=8.29 as=1.16 ps=8.29 w=8 l=4
X228 net1 vt0 ix_sq GND sky130_fd_pr__nfet_01v8 ad=2.32 pd=16.58 as=2.32 ps=16.58 w=8 l=4
X229 const_curr sq_out vdd_comp vdd sky130_fd_pr__pfet_01v8 ad=1.16 pd=8.29 as=1.16 ps=8.29 w=8 l=4
X230 GND GND GND GND sky130_fd_pr__nfet_01v8 ad=2.32 pd=16.58 as=0 ps=0 w=8 l=4
X231 GND vt0 GND GND sky130_fd_pr__nfet_01v8 ad=2.32 pd=16.58 as=0 ps=0 w=8 l=4
X232 vdd_comp lin_out const_curr vdd sky130_fd_pr__pfet_01v8 ad=1.16 pd=8.29 as=1.16 ps=8.29 w=8 l=4
X233 iy_sq iy_sq net1 GND sky130_fd_pr__nfet_01v8 ad=2.32 pd=16.58 as=2.32 ps=16.58 w=8 l=4
X234 lin_out lin_out vdd_comp vdd sky130_fd_pr__pfet_01v8 ad=1.16 pd=8.29 as=1.16 ps=8.29 w=8 l=4
X235 GND GND GND GND sky130_fd_pr__nfet_01v8 ad=2.32 pd=16.58 as=0 ps=0 w=8 l=4
X236 sq_out vt0 net2 GND sky130_fd_pr__nfet_01v8 ad=2.32 pd=16.58 as=2.32 ps=16.58 w=8 l=4
X237 vdd net5 net6 vdd sky130_fd_pr__pfet_01v8 ad=0.58 pd=4.29 as=0.58 ps=4.29 w=4 l=2
X238 sq_out vt0 net2 GND sky130_fd_pr__nfet_01v8 ad=2.32 pd=16.58 as=2.32 ps=16.58 w=8 l=4
X239 net2 iy_sq iz_sq GND sky130_fd_pr__nfet_01v8 ad=2.32 pd=16.58 as=2.32 ps=16.58 w=8 l=4
X240 lin_out lin_out vdd_comp vdd sky130_fd_pr__pfet_01v8 ad=1.16 pd=8.29 as=1.16 ps=8.29 w=8 l=4
X241 lin_out lin_out vdd_comp vdd sky130_fd_pr__pfet_01v8 ad=1.16 pd=8.29 as=1.16 ps=8.29 w=8 l=4
X242 GND vt0 GND GND sky130_fd_pr__nfet_01v8 ad=2.32 pd=16.58 as=0 ps=0 w=8 l=4
X243 GND GND GND GND sky130_fd_pr__nfet_01v8 ad=2.32 pd=16.58 as=0 ps=0 w=8 l=4
X244 net5 const_curr GND GND sky130_fd_pr__nfet_01v8 ad=1.16 pd=8.29 as=1.16 ps=8.29 w=8 l=2
X245 vdd_comp sq_out sq_out vdd sky130_fd_pr__pfet_01v8 ad=1.16 pd=8.29 as=1.16 ps=8.29 w=8 l=4
X246 sq_out sq_out vdd_comp vdd sky130_fd_pr__pfet_01v8 ad=1.16 pd=8.29 as=1.16 ps=8.29 w=8 l=4
X247 net2 iy_sq iz_sq GND sky130_fd_pr__nfet_01v8 ad=2.32 pd=16.58 as=2.32 ps=16.58 w=8 l=4
X248 net4 iy_lin iz_lin GND sky130_fd_pr__nfet_01v8 ad=2.32 pd=16.58 as=2.32 ps=16.58 w=8 l=4
X249 GND GND GND GND sky130_fd_pr__nfet_01v8 ad=2.32 pd=16.58 as=0 ps=0 w=8 l=4
X250 ix_lin vt0 net3 GND sky130_fd_pr__nfet_01v8 ad=2.32 pd=16.58 as=2.32 ps=16.58 w=8 l=4
X251 const_curr sq_out vdd_comp vdd sky130_fd_pr__pfet_01v8 ad=1.16 pd=8.29 as=1.16 ps=8.29 w=8 l=4
X252 vdd_comp sq_out const_curr vdd sky130_fd_pr__pfet_01v8 ad=1.16 pd=8.29 as=1.16 ps=8.29 w=8 l=4
X253 GND GND GND GND sky130_fd_pr__nfet_01v8 ad=2.32 pd=16.58 as=0 ps=0 w=8 l=4
X254 ix_sq vt0 net1 GND sky130_fd_pr__nfet_01v8 ad=2.32 pd=16.58 as=2.32 ps=16.58 w=8 l=4
X255 net5 const_curr GND GND sky130_fd_pr__nfet_01v8 ad=1.16 pd=8.29 as=1.16 ps=8.29 w=8 l=2
X256 GND vt0 GND GND sky130_fd_pr__nfet_01v8 ad=2.32 pd=16.58 as=0 ps=0 w=8 l=4
X257 net2 vt0 sq_out GND sky130_fd_pr__nfet_01v8 ad=2.32 pd=16.58 as=2.32 ps=16.58 w=8 l=4
X258 net2 iy_sq iz_sq GND sky130_fd_pr__nfet_01v8 ad=2.32 pd=16.58 as=2.32 ps=16.58 w=8 l=4
X259 GND vt0 GND GND sky130_fd_pr__nfet_01v8 ad=2.32 pd=16.58 as=0 ps=0 w=8 l=4
X260 vdd net5 net6 vdd sky130_fd_pr__pfet_01v8 ad=0.58 pd=4.29 as=0.58 ps=4.29 w=4 l=2
X261 const_curr lin_out vdd_comp vdd sky130_fd_pr__pfet_01v8 ad=1.16 pd=8.29 as=1.16 ps=8.29 w=8 l=4
X262 const_curr lin_out vdd_comp vdd sky130_fd_pr__pfet_01v8 ad=1.16 pd=8.29 as=1.16 ps=8.29 w=8 l=4
X263 const_curr lin_out vdd_comp vdd sky130_fd_pr__pfet_01v8 ad=1.16 pd=8.29 as=1.16 ps=8.29 w=8 l=4
X264 net6 net5 vdd vdd sky130_fd_pr__pfet_01v8 ad=0.58 pd=4.29 as=0.58 ps=4.29 w=4 l=2
X265 net4 iy_lin iz_lin GND sky130_fd_pr__nfet_01v8 ad=2.32 pd=16.58 as=2.32 ps=16.58 w=8 l=4
X266 net6 net5 vdd vdd sky130_fd_pr__pfet_01v8 ad=0.58 pd=4.29 as=0.58 ps=4.29 w=4 l=2
X267 vdd_comp lin_out lin_out vdd sky130_fd_pr__pfet_01v8 ad=1.16 pd=8.29 as=1.16 ps=8.29 w=8 l=4
X268 GND GND GND GND sky130_fd_pr__nfet_01v8 ad=2.32 pd=16.58 as=0 ps=0 w=8 l=4
X269 net4 iy_lin iz_lin GND sky130_fd_pr__nfet_01v8 ad=2.32 pd=16.58 as=2.32 ps=16.58 w=8 l=4
X270 sq_out sq_out vdd_comp vdd sky130_fd_pr__pfet_01v8 ad=1.16 pd=8.29 as=1.16 ps=8.29 w=8 l=4
X271 const_curr sq_out vdd_comp vdd sky130_fd_pr__pfet_01v8 ad=1.16 pd=8.29 as=1.16 ps=8.29 w=8 l=4
X272 net2 vt0 sq_out GND sky130_fd_pr__nfet_01v8 ad=2.32 pd=16.58 as=2.32 ps=16.58 w=8 l=4
X273 sq_out sq_out vdd_comp vdd sky130_fd_pr__pfet_01v8 ad=1.16 pd=8.29 as=1.16 ps=8.29 w=8 l=4
X274 GND const_curr const_curr GND sky130_fd_pr__nfet_01v8 ad=1.16 pd=8.29 as=2.32 ps=16.58 w=8 l=4
X275 net5 const_curr GND GND sky130_fd_pr__nfet_01v8 ad=1.16 pd=8.29 as=1.16 ps=8.29 w=8 l=2
X276 GND GND GND GND sky130_fd_pr__nfet_01v8 ad=2.32 pd=16.58 as=0 ps=0 w=8 l=4
X277 sq_out vt0 net2 GND sky130_fd_pr__nfet_01v8 ad=2.32 pd=16.58 as=2.32 ps=16.58 w=8 l=4
X278 vdd_comp sq_out sq_out vdd sky130_fd_pr__pfet_01v8 ad=1.16 pd=8.29 as=1.16 ps=8.29 w=8 l=4
X279 const_curr const_curr GND GND sky130_fd_pr__nfet_01v8 ad=1.16 pd=8.29 as=1.16 ps=8.29 w=8 l=4
X280 GND const_curr net5 GND sky130_fd_pr__nfet_01v8 ad=1.16 pd=8.29 as=1.16 ps=8.29 w=8 l=2
X281 sq_out vt0 net2 GND sky130_fd_pr__nfet_01v8 ad=2.32 pd=16.58 as=2.32 ps=16.58 w=8 l=4
X282 lin_out lin_out vdd_comp vdd sky130_fd_pr__pfet_01v8 ad=1.16 pd=8.29 as=1.16 ps=8.29 w=8 l=4
X283 GND GND GND GND sky130_fd_pr__nfet_01v8 ad=2.32 pd=16.58 as=0 ps=0 w=8 l=4
X284 lin_out lin_out vdd_comp vdd sky130_fd_pr__pfet_01v8 ad=1.16 pd=8.29 as=1.16 ps=8.29 w=8 l=4
X285 GND GND GND GND sky130_fd_pr__nfet_01v8 ad=2.32 pd=16.58 as=0 ps=0 w=8 l=4
X286 GND GND GND GND sky130_fd_pr__nfet_01v8 ad=2.32 pd=16.58 as=0 ps=0 w=8 l=4
X287 GND GND GND GND sky130_fd_pr__nfet_01v8 ad=2.32 pd=16.58 as=0 ps=0 w=8 l=4
X288 ix_sq vt0 net1 GND sky130_fd_pr__nfet_01v8 ad=2.32 pd=16.58 as=2.32 ps=16.58 w=8 l=4
X289 net1 iy_sq iy_sq GND sky130_fd_pr__nfet_01v8 ad=2.32 pd=16.58 as=2.32 ps=16.58 w=8 l=4
X290 net2 iy_sq iz_sq GND sky130_fd_pr__nfet_01v8 ad=2.32 pd=16.58 as=2.32 ps=16.58 w=8 l=4
X291 ix_lin vt0 net3 GND sky130_fd_pr__nfet_01v8 ad=2.32 pd=16.58 as=2.32 ps=16.58 w=8 l=4
X292 GND vt0 GND GND sky130_fd_pr__nfet_01v8 ad=2.32 pd=16.58 as=0 ps=0 w=8 l=4
X293 vdd_comp lin_out const_curr vdd sky130_fd_pr__pfet_01v8 ad=1.16 pd=8.29 as=1.16 ps=8.29 w=8 l=4
X294 GND const_curr const_curr GND sky130_fd_pr__nfet_01v8 ad=1.16 pd=8.29 as=1.16 ps=8.29 w=8 l=4
X295 GND GND GND GND sky130_fd_pr__nfet_01v8 ad=2.32 pd=16.58 as=0 ps=0 w=8 l=4
X296 GND GND GND GND sky130_fd_pr__nfet_01v8 ad=2.32 pd=16.58 as=0 ps=0 w=8 l=4
X297 const_curr sq_out vdd_comp vdd sky130_fd_pr__pfet_01v8 ad=1.16 pd=8.29 as=1.16 ps=8.29 w=8 l=4
X298 vdd_comp sq_out const_curr vdd sky130_fd_pr__pfet_01v8 ad=1.16 pd=8.29 as=1.16 ps=8.29 w=8 l=4
X299 net4 iz_lin out GND sky130_fd_pr__nfet_01v8 ad=0.348 pd=2.98 as=0.348 ps=2.98 w=1.2 l=4
X300 GND GND GND GND sky130_fd_pr__nfet_01v8 ad=2.32 pd=16.58 as=0 ps=0 w=8 l=4
X301 iy_lin iy_lin net3 GND sky130_fd_pr__nfet_01v8 ad=2.32 pd=16.58 as=2.32 ps=16.58 w=8 l=4
X302 GND GND GND GND sky130_fd_pr__nfet_01v8 ad=2.32 pd=16.58 as=0 ps=0 w=8 l=4
X303 net2 vt0 sq_out GND sky130_fd_pr__nfet_01v8 ad=2.32 pd=16.58 as=2.32 ps=16.58 w=8 l=4
X304 net5 const_curr GND GND sky130_fd_pr__nfet_01v8 ad=1.16 pd=8.29 as=1.16 ps=8.29 w=8 l=2
X305 lin_out vt0 net4 GND sky130_fd_pr__nfet_01v8 ad=2.32 pd=16.58 as=2.32 ps=16.58 w=8 l=4
X306 net1 iy_sq iy_sq GND sky130_fd_pr__nfet_01v8 ad=2.32 pd=16.58 as=2.32 ps=16.58 w=8 l=4
X307 vdd_comp lin_out lin_out vdd sky130_fd_pr__pfet_01v8 ad=1.16 pd=8.29 as=1.16 ps=8.29 w=8 l=4
X308 net2 vt0 sq_out GND sky130_fd_pr__nfet_01v8 ad=2.32 pd=16.58 as=2.32 ps=16.58 w=8 l=4
X309 ix_lin vt0 net3 GND sky130_fd_pr__nfet_01v8 ad=2.32 pd=16.58 as=2.32 ps=16.58 w=8 l=4
X310 sq_out vt0 net2 GND sky130_fd_pr__nfet_01v8 ad=2.32 pd=16.58 as=2.32 ps=16.58 w=8 l=4
X311 net1 iy_sq iy_sq GND sky130_fd_pr__nfet_01v8 ad=2.32 pd=16.58 as=2.32 ps=16.58 w=8 l=4
X312 net2 vt0 sq_out GND sky130_fd_pr__nfet_01v8 ad=2.32 pd=16.58 as=2.32 ps=16.58 w=8 l=4
X313 GND GND GND GND sky130_fd_pr__nfet_01v8 ad=2.32 pd=16.58 as=0 ps=0 w=8 l=4
X314 GND GND GND GND sky130_fd_pr__nfet_01v8 ad=2.32 pd=16.58 as=0 ps=0 w=8 l=4
X315 vdd_comp sq_out sq_out vdd sky130_fd_pr__pfet_01v8 ad=1.16 pd=8.29 as=1.16 ps=8.29 w=8 l=4
X316 GND GND GND GND sky130_fd_pr__nfet_01v8 ad=2.32 pd=16.58 as=0 ps=0 w=8 l=4
X317 net2 vt0 sq_out GND sky130_fd_pr__nfet_01v8 ad=2.32 pd=16.58 as=2.32 ps=16.58 w=8 l=4
X318 net3 vt0 ix_lin GND sky130_fd_pr__nfet_01v8 ad=2.32 pd=16.58 as=2.32 ps=16.58 w=8 l=4
X319 net1 iy_sq iy_sq GND sky130_fd_pr__nfet_01v8 ad=2.32 pd=16.58 as=2.32 ps=16.58 w=8 l=4
X320 iz_sq iy_sq net2 GND sky130_fd_pr__nfet_01v8 ad=2.32 pd=16.58 as=2.32 ps=16.58 w=8 l=4
X321 GND const_curr const_curr GND sky130_fd_pr__nfet_01v8 ad=1.16 pd=8.29 as=1.16 ps=8.29 w=8 l=4
X322 iz_sq iy_sq net2 GND sky130_fd_pr__nfet_01v8 ad=2.32 pd=16.58 as=2.32 ps=16.58 w=8 l=4
X323 vdd_comp lin_out const_curr vdd sky130_fd_pr__pfet_01v8 ad=1.16 pd=8.29 as=1.16 ps=8.29 w=8 l=4
X324 vdd_comp sq_out sq_out vdd sky130_fd_pr__pfet_01v8 ad=1.16 pd=8.29 as=1.16 ps=8.29 w=8 l=4
X325 GND vt0 GND GND sky130_fd_pr__nfet_01v8 ad=2.32 pd=16.58 as=0 ps=0 w=8 l=4
X326 i_v_out net6 GND GND sky130_fd_pr__nfet_01v8 ad=2.32 pd=16.58 as=1.16 ps=8.29 w=8 l=2
X327 net2 iy_sq iz_sq GND sky130_fd_pr__nfet_01v8 ad=2.32 pd=16.58 as=2.32 ps=16.58 w=8 l=4
X328 ix_lin vt0 net3 GND sky130_fd_pr__nfet_01v8 ad=2.32 pd=16.58 as=2.32 ps=16.58 w=8 l=4
X329 lin_out lin_out vdd_comp vdd sky130_fd_pr__pfet_01v8 ad=2.32 pd=16.58 as=1.16 ps=8.29 w=8 l=4
X330 iy_lin iy_lin net3 GND sky130_fd_pr__nfet_01v8 ad=2.32 pd=16.58 as=2.32 ps=16.58 w=8 l=4
X331 vdd_comp lin_out const_curr vdd sky130_fd_pr__pfet_01v8 ad=1.16 pd=8.29 as=1.16 ps=8.29 w=8 l=4
X332 const_curr lin_out vdd_comp vdd sky130_fd_pr__pfet_01v8 ad=1.16 pd=8.29 as=1.16 ps=8.29 w=8 l=4
X333 iy_lin iy_lin net3 GND sky130_fd_pr__nfet_01v8 ad=2.32 pd=16.58 as=2.32 ps=16.58 w=8 l=4
X334 GND GND GND GND sky130_fd_pr__nfet_01v8 ad=2.32 pd=16.58 as=0 ps=0 w=8 l=4
X335 sq_out sq_out vdd_comp vdd sky130_fd_pr__pfet_01v8 ad=1.16 pd=8.29 as=1.16 ps=8.29 w=8 l=4
X336 const_curr sq_out vdd_comp vdd sky130_fd_pr__pfet_01v8 ad=2.32 pd=16.58 as=1.16 ps=8.29 w=8 l=4
X337 vdd_comp sq_out sq_out vdd sky130_fd_pr__pfet_01v8 ad=1.16 pd=8.29 as=2.32 ps=16.58 w=8 l=4
X338 vdd_comp sq_out const_curr vdd sky130_fd_pr__pfet_01v8 ad=1.16 pd=8.29 as=1.16 ps=8.29 w=8 l=4
X339 sq_out sq_out vdd_comp vdd sky130_fd_pr__pfet_01v8 ad=1.16 pd=8.29 as=1.16 ps=8.29 w=8 l=4
X340 vdd_comp lin_out lin_out vdd sky130_fd_pr__pfet_01v8 ad=1.16 pd=8.29 as=1.16 ps=8.29 w=8 l=4
.ends
